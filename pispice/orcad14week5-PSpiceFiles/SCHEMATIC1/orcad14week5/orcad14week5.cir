** Profile: "SCHEMATIC1-orcad14week5"  [ C:\Users\OHSEHOON\Desktop\pispice\orcad14week5-PSpiceFiles\SCHEMATIC1\orcad14week5.sim ]

** Creating circuit file "orcad14week5.cir"
** WARNING: THIS AUTOMATICALLY GENERATED FILE MAY BE OVERWRITTEN BY SUBSEQUENT SIMULATIONS

*Libraries:
* Profile Libraries :
* Local Libraries :
* From [PSPICE NETLIST] section of C:\Users\OHSEHOON\AppData\Roaming\SPB_Data\cdssetup\OrCAD_PSpice\17.2.0\PSpice.ini file:
.lib "nomd.lib"

*Analysis directives:
.DC LIN V_V2 0 5 0.1
.STEP LIN I_I2 0 200u 40u
.OPTIONS ADVCONV
.PROBE64 V(alias(*)) I(alias(*)) W(alias(*)) D(alias(*)) NOISE(alias(*))
.INC "..\SCHEMATIC1.net"

.END
